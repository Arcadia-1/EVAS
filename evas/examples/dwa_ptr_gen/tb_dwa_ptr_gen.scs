// dwa_ptr_gen: DWA pointer rotation generator
simulator lang=spectre
global 0

ahdl_include "dwa_ptr_gen.va"

// Clock: 100ns period
Vclk (clk_i 0) vsource type=pulse val0=0 val1=0.9 period=100n delay=5n rise=1n fall=1n width=48n

// Reset: deassert at 20ns (active-low)
Vrst_n (rst_ni 0) vsource type=pwl \
        wave=[0 0 19n 0 20n 0.9 5000n 0.9]

// 4-bit MSB code input: cycle through codes 3, 5, 2, 7, 1, 4, 6, 8
// MSB-first bus: code_msb_i_3 code_msb_i_2 code_msb_i_1 code_msb_i_0
// code=3  = 0b0011 at t=50ns  (bits 1,0 high)
// code=5  = 0b0101 at t=150ns (bits 2,0 high)
// code=2  = 0b0010 at t=250ns (bit 1 high)
// code=7  = 0b0111 at t=350ns (bits 2,1,0 high)
// code=1  = 0b0001 at t=450ns (bit 0 high)
// code=4  = 0b0100 at t=550ns (bit 2 high)

Vcode0 (code_msb_i_0 0) vsource type=pwl \
    wave=[0 0 49n 0 50n 0.9 149n 0.9 150n 0 249n 0 250n 0 349n 0 350n 0.9 449n 0.9 450n 0.9 549n 0.9 550n 0 1000n 0]
Vcode1 (code_msb_i_1 0) vsource type=pwl \
    wave=[0 0 49n 0 50n 0.9 149n 0.9 150n 0 249n 0 250n 0.9 349n 0.9 350n 0.9 449n 0.9 450n 0 549n 0 550n 0 1000n 0]
Vcode2 (code_msb_i_2 0) vsource type=pwl \
    wave=[0 0 49n 0 50n 0 149n 0 150n 0.9 249n 0.9 250n 0 349n 0 350n 0.9 449n 0.9 450n 0 549n 0 550n 0.9 1000n 0.9]
Vcode3 (code_msb_i_3 0) vsource type=dc dc=0

// DUT: ports clk_i rst_ni code_msb_i[3:0] cell_en_o[15:0] ptr_o[15:0]
XDUT (clk_i rst_ni \
      code_msb_i_3 code_msb_i_2 code_msb_i_1 code_msb_i_0 \
      cell_en_15 cell_en_14 cell_en_13 cell_en_12 cell_en_11 cell_en_10 cell_en_9 cell_en_8 \
      cell_en_7 cell_en_6 cell_en_5 cell_en_4 cell_en_3 cell_en_2 cell_en_1 cell_en_0 \
      ptr_15 ptr_14 ptr_13 ptr_12 ptr_11 ptr_10 ptr_9 ptr_8 \
      ptr_7 ptr_6 ptr_5 ptr_4 ptr_3 ptr_2 ptr_1 ptr_0) \
      dwa_ptr_gen vdd=0.9 vth=0.45 ptr_init=0

tran tran stop=1000n maxstep=1n
save clk_i:2e rst_ni:d \
     cell_en_15:d cell_en_14:d cell_en_13:d cell_en_12:d cell_en_11:d cell_en_10:d cell_en_9:d cell_en_8:d \
     cell_en_7:d cell_en_6:d cell_en_5:d cell_en_4:d cell_en_3:d cell_en_2:d cell_en_1:d cell_en_0:d \
     ptr_15:d ptr_14:d ptr_13:d ptr_12:d ptr_11:d ptr_10:d ptr_9:d ptr_8:d \
     ptr_7:d ptr_6:d ptr_5:d ptr_4:d ptr_3:d ptr_2:d ptr_1:d ptr_0:d
