// gain_calibration: cross-correlation gain estimation convergence.
//
// Signal path:
//   VIN = DC (diff = 0) --> dither_adder <-- LFSR (DPN)
//                                  |
//                           gain_amp_fixed  (ACTUAL_GAIN = GAIN_NOM * (1 + GAIN_ERR))
//                                  |
//                            VAMP (diff) --> gain_estimator --> strobe at N=2^8..2^16
//
// Gain estimation via cross-correlation:
//   A_est = sum( V(VAMP_diff) * sign(DPN) ) / (N * DITHER_AMP)
//
// 2^16 total samples at 50 MHz = 1.31072 ms

simulator lang=spectre
global 0

ahdl_include "lfsr.va"
ahdl_include "dither_adder.va"
ahdl_include "gain_amp_fixed.va"
ahdl_include "gain_estimator.va"

parameters vdd=0.9 GAIN_NOM=8.0 GAIN_ERR=0.08 fs=50e6
parameters ACTUAL_GAIN=8.64
parameters DITHER_AMP=0.014063

// ── Supplies ──────────────────────────────────────────────────────────────────
Vvdd (vdd 0) vsource dc=vdd
Vvss (vss 0) vsource dc=0

// ── Clock: 50 MHz ─────────────────────────────────────────────────────────────
Vclk (clk 0) vsource type=pulse val0=0 val1=vdd period=20n delay=5n \
             rise=1n fall=1n width=9n

// ── Reset: deassert after 40 ns ───────────────────────────────────────────────
Vrst_n (rst_n 0) vsource type=pwl wave=[0 0  39.5n 0  40n vdd  1.5m vdd]

// ── LFSR enable ───────────────────────────────────────────────────────────────
Ven (en 0) vsource dc=vdd

// ── VIN = DC at vdd/2 (zero differential input) ───────────────────────────────
Vvinp (vinp 0) vsource dc=0.45
Vvinn (vinn 0) vsource dc=0.45

// ── LFSR ──────────────────────────────────────────────────────────────────────
ILFSR (dpn vdd vss clk en rst_n) lfsr seed=42

// ── Dither adder (VIN_diff=0; only PN dither passes through) ─────────────────
IDITH (vinp vinn dpn vdin_p vdin_n) dither_adder \
      vdd=vdd vth=0.45 DITHER_AMP=DITHER_AMP

// ── Fixed-gain amplifier ──────────────────────────────────────────────────────
IAMP (vdin_p vdin_n vamp_p vamp_n) gain_amp_fixed \
     vdd=vdd ACTUAL_GAIN=ACTUAL_GAIN

// ── Gain estimator (open-loop, strobe at N = 2^8 .. 2^16) ────────────────────
IEST (clk rst_n vamp_p vamp_n dpn) gain_estimator \
     vth=0.45 N_TOTAL=65536 DITHER_AMP=DITHER_AMP

// ── Simulation: 2^16 * 20 ns = 1.31072 ms; margin -> 1.4 ms ──────────────────
tran tran stop=1.4m maxstep=1n

save clk:2e dpn:2e rst_n:d
save vamp_p:3f vamp_n:3f
