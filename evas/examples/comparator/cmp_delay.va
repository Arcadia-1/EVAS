`include "constants.vams"
`include "disciplines.vams"

// Comparator with regeneration-delay model: td = td_scale / |Vdiff_eff|
// Models metastability: smaller differential input → longer output delay.
module cmp_delay (
    input  electrical CLK,
    input  electrical VINN,
    input  electrical VINP,
    output electrical DCMPN,
    output electrical DCMPP,
    output electrical LP,
    output electrical LM,
    inout  electrical VSS,
    inout  electrical VDD
);

parameter real voffset  = 0.0;
parameter real td_scale = 1e-12;   // [V·s]:  td = td_scale / |Vdiff|
parameter real td_min   = 50e-12;  // minimum delay (floor)
parameter real td_max   = 8e-9;    // maximum delay (ceiling)

real vdd;
integer xoutp, xoutn;
real tedge = 20p;
real td;
real vdiff_eff;

analog begin
    vdd = V(VDD);

    @(initial_step)
        td = td_min;

    @(cross(V(CLK) - vdd*0.5, +1)) begin
        vdiff_eff = V(VINP) - V(VINN) - voffset;
        if (vdiff_eff < 0) vdiff_eff = -vdiff_eff;
        if (vdiff_eff < 1e-6) vdiff_eff = 1e-6;
        td = td_scale / vdiff_eff;
        if (td < td_min) td = td_min;
        if (td > td_max) td = td_max;

        if (V(VINP) - V(VINN) - voffset > 0) begin
            xoutp = 1;
            xoutn = 0;
        end else begin
            xoutp = 0;
            xoutn = 1;
        end
        $strobe("[cmp_delay] t=%.3f ns | diff=%.4fmV | td=%.3f ns | dec=%d",
                $abstime*1e9, (V(VINP)-V(VINN))*1e3, td*1e9, xoutp);
    end

    @(cross(V(CLK) - vdd*0.5, -1)) begin
        xoutp = 0;
        xoutn = 0;
    end

    V(DCMPP) <+ transition(vdd * xoutp, td, tedge, tedge);
    V(DCMPN) <+ transition(vdd * xoutn, td, tedge, tedge);

end

endmodule
