`include "constants.vams"
`include "disciplines.vams"

`default_transition 10p

module cmp_offset_search(
    input electrical CLK,
    input electrical DCMPP,
    input electrical VINCM,     // New input for common-mode voltage
    output electrical VINP,
    output electrical VINN
);

parameter vdd = 0.8;
real vin = 0;
real step = 100m;
integer sign = 1;

analog begin

    @(initial_step)
        $strobe("[cmp_offset_search] INIT | vdd=%.3gV | step=%.5gV", vdd, step);

    // Trigger on the falling edge of CLK (threshold at 0.5*vdd)
    @ (cross(V(CLK) - 0.5 * vdd, -1)) begin
        // Comparator decision direction
        sign = V(DCMPP) > 0.5 * vdd;
        // Update offset value vin
        vin = vin - (2 * sign - 1) * step;
        // Binary search step reduction
        step = step / 2.0;
        $strobe("[cmp_offset_search] t=%.3f ns | sign=%d | vin=%.5gV | step=%.5gV", $abstime*1e9, sign, vin, step);
    end

    // Output differential around VINCM instead of vdd/2
    V(VINP) <+ (V(VINCM) + 0.5 * vin);
    V(VINN) <+ (V(VINCM) - 0.5 * vin);

end

endmodule
