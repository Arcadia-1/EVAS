// ADC_4B: 4-bit SAR ADC — full sweep from GND to VDD
simulator lang=spectre
global 0

ahdl_include "../veriloga/ADC_4B.va"

// Parameters
parameters vdd=0.9

// Conversion clock: 20ns period
Vclks (clks 0) vsource type=pulse val0=0 val1=vdd period=20n \
        rise=100p fall=100p

// Input: slow ramp from 0V (GND) to 0.9V (VDD) over the simulation window
// 16 clock cycles × 20ns = 320ns for a 4-bit ADC to sweep all codes
Vvin (vin 0) vsource type=pwl wave=[0 0.0 400e-9 0.9]

// DUT (port order: VIN CLKS DOUT[3] DOUT[2] DOUT[1] DOUT[0])
XDUT (vin clks dout_3 dout_2 dout_1 dout_0) ADC_4B vdd=vdd

// Combined digital output: DOUT_combined = 8*D3 + 4*D2 + 2*D1 + D0
// Scaled by 1/vdd so each bit contributes its binary weight as an integer
Ecomb (dout_combined 0) vcvs gains=[8 4 2 1] \
        in1p=dout_3 in1n=0 \
        in2p=dout_2 in2n=0 \
        in3p=dout_1 in3n=0 \
        in4p=dout_0 in4n=0

tran tran stop=400n maxstep=100p

save vin clks dout_3 dout_2 dout_1 dout_0 dout_combined
