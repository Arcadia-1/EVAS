// edge_interval_timer: Measures rising-edge-to-rising-edge delay in ps
simulator lang=spectre
global 0

ahdl_include "edge_interval_timer.va"

// CLK_1: reference clock, 200ns period
Vclk1 (CLK_1 0) vsource type=pulse val0=0 val1=0.9 period=200n delay=5n rise=1n fall=1n width=98n

// CLK_2: delayed clock, same period but delayed by ~25ns
Vclk2 (CLK_2 0) vsource type=pulse val0=0 val1=0.9 period=200n delay=30n rise=1n fall=1n width=98n

XDUT (CLK_1 CLK_2 OUT_PS) edge_interval_timer VTH=0.4

tran tran stop=4000n maxstep=1n
save CLK_1:2e CLK_2:2e OUT_PS:3f
