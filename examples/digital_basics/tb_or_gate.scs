// tb_or_gate.scs — OR gate truth-table sweep
// Input sequence (A,B): (0,0)→(0,1)→(1,0)→(1,1), 2 ns per state
//   t=0..2n   A=0 B=0 → out=0
//   t=2..4n   A=0 B=1 → out=1
//   t=4..6n   A=1 B=0 → out=1
//   t=6..8n   A=1 B=1 → out=1
simulator lang=spectre
global 0

ahdl_include "or_gate.va"

VA (a 0) vsource type=pwl wave=[0 0  3.985n 0  4.015n 0.8  8n 0.8]

VB (b 0) vsource type=pwl wave=[0 0  1.985n 0  2.015n 0.8 \
                                 3.985n 0.8  4.015n 0 \
                                 5.985n 0    6.015n 0.8  8n 0.8]

XDUT (a b y) or_gate

tran tran stop=8n maxstep=0.1n
save a:2e b:2e y:2e
