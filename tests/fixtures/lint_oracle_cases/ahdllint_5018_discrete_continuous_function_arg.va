module discrete_continuous_function_arg(clk, out);
    input clk;
    output out;
    electrical clk, out;
    integer state;

    analog begin
        @(initial_step) state = 0;
        @(timer(0, 1n)) state = 1 - state;
        V(out) <+ slew(state, 1e9, 1e9);
    end
endmodule
