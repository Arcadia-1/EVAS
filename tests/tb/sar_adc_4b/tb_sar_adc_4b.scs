// ADC_4B: 4-bit SAR ADC — full sweep from GND to VDD
simulator lang=spectre
global 0

ahdl_include "sar_adc_4b.va"

// Parameters
parameters vdd=0.9

// Conversion clock: 20ns period
Vclks (clks 0) vsource type=pulse val0=0 val1=vdd period=20n \
        rise=100p fall=100p

// Input: ramp from 0V (GND) to VDD over 16 clock cycles (320ns)
// Start 1 cycle (20ns) later so the first conversion sees a clean ramp
Vvin (vin 0) vsource type=pwl wave=[0 0.0 20e-9 0.0 340e-9 0.9]

// DUT (port order: VIN CLKS DOUT[3] DOUT[2] DOUT[1] DOUT[0])
XDUT (vin clks dout_3 dout_2 dout_1 dout_0) sar_adc_4b vdd=vdd

tran tran stop=360n maxstep=100p

save clks vin dout_3 dout_2 dout_1 dout_0
