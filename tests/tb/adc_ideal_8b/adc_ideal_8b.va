module adc_ideal_8b (
    input  electrical        vin,
    input  electrical        rst_n,
    output electrical [3:0]  dout
);

    parameter real vstep      = 0.056;  // V per LSB  (0.9/16 ≈ 0.056)
    parameter real tr         = 10p;
    parameter real vth        = 0.4;    // threshold for logic-1 detect
    parameter real voh        = 0.9;    // output high voltage
    parameter real vol        = 0.0;    // output low voltage

    integer code;
    real    v_in;
    genvar k;

    analog begin
        @(initial_step)
            $strobe("[adc_ideal_4b] INIT: vstep=%g, vth=%g, voh=%g", vstep, vth, voh);

        v_in = V(vin);

        if (V(rst_n) < vth) begin
            code = 0;
        end
        else begin
            code = v_in / vstep;
            if (code < 0)  code = 0;
            if (code > 15) code = 15;
        end

        for (k = 0; k < 4; k = k + 1) begin
            if ((code >> k) & 1)
                V(dout[k]) <+ transition(voh, 0, tr, tr);
            else
                V(dout[k]) <+ transition(vol, 0, tr, tr);
        end
    end

endmodule
