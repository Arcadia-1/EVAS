// adc_ideal_4b: Ideal 4-bit combinational ADC — ramp sweep 0 → vdd
simulator lang=spectre
global 0

ahdl_include "adc_ideal_8b.va"

parameters vdd=0.9 vstep=0.056

// Reset: active-low, held for 2 cycles (40ns), deasserts at 40ns
Vrst_n (rst_n 0) vsource type=pwl wave=[0 0 39e-9 0 40e-9 vdd 420e-9 vdd]

// Vin: held at 0 during reset, then steps through all 16 codes (20ns each)
// 16 codes × 20ns = 320ns, starting at 40ns, ending at 360ns
Vvin (vin 0) vsource type=pwl wave=[ \
        0 0  40e-9 0 \
        60e-9 0.056   80e-9 0.112  100e-9 0.168  120e-9 0.224 \
        140e-9 0.280  160e-9 0.336  180e-9 0.392  200e-9 0.448 \
        220e-9 0.504  240e-9 0.560  260e-9 0.616  280e-9 0.672 \
        300e-9 0.728  320e-9 0.784  340e-9 0.840  420e-9 0.840]

// DUT (port order: VIN RST_N DOUT[3] DOUT[2] DOUT[1] DOUT[0])
XDUT (vin rst_n dout_3 dout_2 dout_1 dout_0) adc_ideal_8b vstep=vstep voh=vdd vth=0.45

tran tran stop=420n maxstep=1n
save vin rst_n dout_3 dout_2 dout_1 dout_0
