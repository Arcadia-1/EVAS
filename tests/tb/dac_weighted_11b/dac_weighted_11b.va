// VerilogA for SAR_11B testbench

`include "constants.vams"
`include "disciplines.vams"

`define NUM_ADC_BITS	12
`default_transition 30p

module dac_weighted_11b(input electrical [`NUM_ADC_BITS:1] DIN, input electrical RDY, output electrical AOUT);

real weight[`NUM_ADC_BITS:1] = {501, 270, 144, 78, 42, 21, 12, 6, 3, 2, 1, 0.5};
real sum;

parameter real vdd = 0.9;
parameter real vth = 0.45;

real aout, cnt;
genvar i;

analog begin
	@(initial_step) begin
		sum = 0.5;
		for(i = `NUM_ADC_BITS; i >= 1; i = i-1) begin
			sum = sum + weight[i];
		end

		// counter, to abandon the first sample
		cnt = 0;
		$strobe("[dac_weighted_11b] INIT: vdd=%g, vth=%g, sum=%g", vdd, vth, sum);
	end

	@(cross(V(RDY)-vth,+1)) begin
		aout = 0;
		if (cnt == 0) begin
			cnt = 1;
		end else begin
			for(i = `NUM_ADC_BITS; i >= 1; i = i-1) begin
				aout = aout + (V(DIN[i]) > vth) * weight[i];
			end
		aout = (aout/sum*2-1)*vdd;

		end
		$strobe("[dac_weighted_11b]: Time=%g ns, cnt=%g, aout=%g", $abstime*1e9, cnt, aout);
	end
	V(AOUT) <+ transition(aout,0);
end

endmodule
