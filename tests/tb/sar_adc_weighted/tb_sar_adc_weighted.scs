// sar_adc_weighted: 12-bit SAR ADC with non-binary weights
// Sweep VIN from 0 to vdd over 64 clock cycles to observe code transitions.
simulator lang=spectre
global 0

ahdl_include "sar_adc_weighted.va"

parameters vdd=0.9

// Conversion clock: 20ns period
Vclks (clks 0) vsource type=pulse val0=0 val1=vdd period=20n \
        rise=100p fall=100p

// Input: ramp from 0 to vdd over 64 cycles (1280ns), starting after 1 cycle
Vvin (vin 0) vsource type=pwl wave=[0 0.0 20e-9 0.0 1300e-9 0.9]

// DUT
XDUT (vin clks \
      dout_11 dout_10 dout_9 dout_8 dout_7 dout_6 \
      dout_5  dout_4  dout_3 dout_2 dout_1 dout_0) \
      sar_adc_weighted vdd=vdd

tran tran stop=1320n maxstep=100p

save clks vin dout_11 dout_10 dout_9 dout_8 dout_7 dout_6 dout_5 dout_4 dout_3 dout_2 dout_1 dout_0
