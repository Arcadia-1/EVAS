`include "constants.vams"
`include "disciplines.vams"

`define NUM_BITS 12
`default_transition 30p

// SAR ADC with non-binary weights matching dac_weighted_11b.
//
// Weights (MSB to LSB): 501, 270, 144, 78, 42, 21, 12, 6, 3, 2, 1, 0.5
// Total = 1081. Input range [0, vdd] maps to output code [0, 4095].
//
// Algorithm: at each step i (MSB first), tentatively assert bit[i].
// If (partial_sum + weight[i]) / total_sum * vdd <= vsampled → keep bit,
// else reject. Identical to the decision made by dac_weighted_11b.

module sar_adc_weighted(
    input  electrical          VIN,
    input  electrical          CLKS,
    output electrical [`NUM_BITS-1:0] DOUT
);

parameter real vdd = 0.9;
parameter real vth = 0.45;

real weight[`NUM_BITS:1];
real total_sum;
real vsampled, vdac_partial;
integer dout_bits[`NUM_BITS:1];
genvar i;

analog begin
    @(initial_step) begin
        // Non-binary weights — same as dac_weighted_11b
        weight[12] = 501; weight[11] = 270; weight[10] = 144;
        weight[9]  = 78;  weight[8]  = 42;  weight[7]  = 21;
        weight[6]  = 12;  weight[5]  = 6;   weight[4]  = 3;
        weight[3]  = 2;   weight[2]  = 1;   weight[1]  = 0.5;

        total_sum = 0;
        for (i = `NUM_BITS; i >= 1; i = i - 1)
            total_sum = total_sum + weight[i];

        for (i = `NUM_BITS; i >= 1; i = i - 1)
            dout_bits[i] = 0;
        $strobe("[sar_adc_weighted] INIT: vdd=%g, vth=%g, total_sum=%g", vdd, vth, total_sum);
    end

    // Track input during sampling phase (CLKS low)
    if (V(CLKS) < vth)
        vsampled = V(VIN);

    // SAR conversion on rising edge of CLKS
    @(cross(V(CLKS) - vth, +1)) begin
        vdac_partial = 0.0;
        for (i = `NUM_BITS; i >= 1; i = i - 1) begin
            if ((vdac_partial + weight[i]) / total_sum * vdd <= vsampled) begin
                dout_bits[i] = 1;
                vdac_partial = vdac_partial + weight[i];
            end else begin
                dout_bits[i] = 0;
            end
        end
        $strobe("[sar_adc_weighted]: Time=%g ns, vsampled=%g, dout[12:1]=%d%d%d%d%d%d%d%d%d%d%d%d",
                $abstime*1e9, vsampled,
                dout_bits[12], dout_bits[11], dout_bits[10], dout_bits[9],
                dout_bits[8],  dout_bits[7],  dout_bits[6],  dout_bits[5],
                dout_bits[4],  dout_bits[3],  dout_bits[2],  dout_bits[1]);
    end

    // Drive output (DOUT[0] = LSB = weight[1], DOUT[11] = MSB = weight[12])
    for (i = `NUM_BITS; i >= 1; i = i - 1)
        V(DOUT[i-1]) <+ transition(dout_bits[i] ? vdd : 0, 0, 30p, 30p);
end

endmodule
