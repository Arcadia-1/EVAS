// dac_onehot_inv_16b: 16-bit one-cold (inverted one-hot) DAC
// Active-low one-hot: exactly one bit is LOW, rest HIGH -> vout = position_of_zero * vstep
simulator lang=spectre
global 0

ahdl_include "dac_onehot_inv_16b.va"

// Reset: deassert at 5ns
Vrst_n (rst_n 0) vsource type=pwl \
        wave=[0 0 4n 0 5n 0.9 3000n 0.9]

// Start with all-high (code=0 since no zero), then step zero position
// At t=50ns:  zero at bit0  -> vout = 0  * 1.0 = 0.0V
// At t=300ns: zero at bit5  -> vout = 5  * 1.0 = 5.0V
// At t=600ns: zero at bit10 -> vout = 10 * 1.0 = 10.0V
// At t=900ns: zero at bit15 -> vout = 15 * 1.0 = 15.0V

// All bits default HIGH (0.9V), then we pull individual bits LOW
// bit0: low at 50ns, goes back high at 300ns
Vd0  (d0  0) vsource type=pwl wave=[0 0.9 49n 0.9 50n 0 299n 0 300n 0.9 3000n 0.9]
Vd1  (d1  0) vsource type=dc dc=0.9
Vd2  (d2  0) vsource type=dc dc=0.9
Vd3  (d3  0) vsource type=dc dc=0.9
Vd4  (d4  0) vsource type=dc dc=0.9
// bit5: low at 300ns, high at 600ns
Vd5  (d5  0) vsource type=pwl wave=[0 0.9 299n 0.9 300n 0 599n 0 600n 0.9 3000n 0.9]
Vd6  (d6  0) vsource type=dc dc=0.9
Vd7  (d7  0) vsource type=dc dc=0.9
Vd8  (d8  0) vsource type=dc dc=0.9
Vd9  (d9  0) vsource type=dc dc=0.9
// bit10: low at 600ns, high at 900ns
Vd10 (d10 0) vsource type=pwl wave=[0 0.9 599n 0.9 600n 0 899n 0 900n 0.9 3000n 0.9]
Vd11 (d11 0) vsource type=dc dc=0.9
Vd12 (d12 0) vsource type=dc dc=0.9
Vd13 (d13 0) vsource type=dc dc=0.9
Vd14 (d14 0) vsource type=dc dc=0.9
// bit15: low at 900ns
Vd15 (d15 0) vsource type=pwl wave=[0 0.9 899n 0.9 900n 0 3000n 0]

// DUT: ports din_onehot[15:0] rst_n vout (MSB-first bus)
XDUT (d15 d14 d13 d12 d11 d10 d9 d8 d7 d6 d5 d4 d3 d2 d1 d0 \
      rst_n vout) dac_onehot_inv_16b vstep=1.0 vth=0.4

tran tran stop=2000n maxstep=1n
save rst_n d15 d14 d13 d12 d11 d10 d9 d8 d7 d6 d5 d4 d3 d2 d1 d0 vout
