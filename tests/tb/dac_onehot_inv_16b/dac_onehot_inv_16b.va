module dac_onehot_inv_16b (
    input  electrical [15:0] din_onehot,
    input  electrical        rst_n,
    output electrical        vout
);

    parameter real vstep      = 1.0;   // 1V per step -> 0..15V
    parameter real tr         = 10p;
    parameter real vth        = 0.4;   // threshold for logic-1 detect
    parameter real XCODE_VOLT = 0.0;   // output when multi-hot

    integer ones_cnt;
    integer idx_sum;
    real    v_target;

    genvar k;

    analog begin
        @(initial_step)
            $strobe("[dac_onehot_inv_16b] INIT: vstep=%g, vth=%g, XCODE_VOLT=%g", vstep, vth, XCODE_VOLT);

        ones_cnt = 0;
        idx_sum  = 0;

        // Check reset first
        if (V(rst_n) < vth) begin
            v_target = 0.0;
        end
        else begin
            // Find the position of the zero (one-cold/one-hot-n)
            for (k = 0; k < 16; k = k + 1) begin
                if (V(din_onehot[k]) <= vth) begin
                    ones_cnt = ones_cnt + 1;
                    idx_sum  = idx_sum + k;
                end
            end

            // Determine target voltage (no transition here)
            if (ones_cnt == 0)
                v_target = 0.0;
            else if (ones_cnt == 1)
                v_target = idx_sum * vstep;   // 0..15V
            else
                v_target = XCODE_VOLT;
        end

        // Single unconditional transition contribution (Spectre-safe)
        V(vout) <+ transition(v_target, 0, tr, tr);
    end

endmodule
