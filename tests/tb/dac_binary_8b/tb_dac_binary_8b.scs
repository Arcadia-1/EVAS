// dac_binary_8b: 8-bit binary DAC
simulator lang=spectre
global 0

ahdl_include "dac_binary_8b.va"

// Reset: deassert at 5ns
Vrst_n (rst_n 0) vsource type=pwl \
        wave=[0 0 4n 0 5n 0.9 3000n 0.9]

// 8-bit binary input: step through codes 0, 16, 32, 64, 128, 192, 255
// Using PWL for each bit
// Code 0   = 0b00000000 at t=10ns
// Code 16  = 0b00010000 at t=200ns  (bit4=1)
// Code 32  = 0b00100000 at t=400ns  (bit5=1)
// Code 64  = 0b01000000 at t=600ns  (bit6=1)
// Code 128 = 0b10000000 at t=800ns  (bit7=1)
// Code 192 = 0b11000000 at t=1000ns (bit7,6=1)
// Code 255 = 0b11111111 at t=1200ns (all bits=1)

Vd0 (din_bin_0 0) vsource type=pwl \
    wave=[0 0 1195n 0 1200n 0.9 3000n 0.9]
Vd1 (din_bin_1 0) vsource type=pwl \
    wave=[0 0 1195n 0 1200n 0.9 3000n 0.9]
Vd2 (din_bin_2 0) vsource type=pwl \
    wave=[0 0 1195n 0 1200n 0.9 3000n 0.9]
Vd3 (din_bin_3 0) vsource type=pwl \
    wave=[0 0 1195n 0 1200n 0.9 3000n 0.9]
Vd4 (din_bin_4 0) vsource type=pwl \
    wave=[0 0 195n 0 200n 0.9 395n 0.9 400n 0 1195n 0 1200n 0.9 3000n 0.9]
Vd5 (din_bin_5 0) vsource type=pwl \
    wave=[0 0 395n 0 400n 0.9 595n 0.9 600n 0 1195n 0 1200n 0.9 3000n 0.9]
Vd6 (din_bin_6 0) vsource type=pwl \
    wave=[0 0 595n 0 600n 0.9 795n 0.9 800n 0 995n 0 1000n 0.9 3000n 0.9]
Vd7 (din_bin_7 0) vsource type=pwl \
    wave=[0 0 795n 0 800n 0.9 3000n 0.9]

// DUT: ports din_bin[7:0] rst_n vout (MSB-first bus)
XDUT (din_bin_7 din_bin_6 din_bin_5 din_bin_4 din_bin_3 din_bin_2 din_bin_1 din_bin_0 \
      rst_n vout) dac_binary_8b vstep=0.05 vth=0.4

tran tran stop=2000n maxstep=1n
save rst_n din_bin_7 din_bin_6 din_bin_5 din_bin_4 din_bin_3 din_bin_2 din_bin_1 din_bin_0 vout
