module dac_binary_8b (
    input  electrical [7:0]  din_bin,
    input  electrical        rst_n,
    output electrical        vout
);

    parameter real vstep      = 1.0;   // 1V per LSB
    parameter real tr         = 10p;
    parameter real vth        = 0.4;   // threshold for logic-1 detect

    integer bin_val;
    real    v_target;

    genvar k;

    analog begin
        @(initial_step)
            $strobe("[dac_binary_8b] INIT: vstep=%g, vth=%g", vstep, vth);

        bin_val = 0;

        // Check reset first
        if (V(rst_n) < vth) begin
            v_target = 0.0;
        end
        else begin
            // Decode 8-bit binary (LSB = bit 0)
            for (k = 0; k < 8; k = k + 1) begin
                if (V(din_bin[k]) > vth) begin
                    bin_val = bin_val + (1 << k);
                end
            end

            // Determine target voltage based on binary value
            v_target = bin_val * vstep;   // 0..255*vstep
        end

        // Single unconditional transition contribution (Spectre-safe)
        V(vout) <+ transition(v_target, 0, tr, tr);
    end

endmodule
